* RBG3-MOTION: charger backfeed when the dock is unpowered (robot undocked, or dock power switched off)
*
* Questions (review Q1): with no diode at the charger output, how much does the pack lose into the
* XL4015 module, and can that backfeed raise the dock pads high enough to fake "docked" (DOCK_V > 20 V)?
*
* Model (the XL4015 module is a black box; its internals are typical CC/CV module values, see README):
* - BUS: pack through fuse + main switch + INA226 (the charger output sits after the switch, spec 02 §1),
*   swept over 12-16.8 V. Switch off = no backfeed at all.
* - Module output: inductor DCR to SW; freewheel Schottky SW <- GND; XL4015 internal high-side switch OFF,
*   worst case assumed to have a body diode SW -> VIN (so VIN is charged from the bus).
* - RFB: the module's CV feedback divider from OUT+ to GND, 10 k total (assumed; 1.25 V reference).
* - IMOD: everything on the module's VIN side (XL4015 Iq 2.1 mA typ / 5 mA max per datasheet, CC op-amp,
*   reference, LEDs), modelled as a resistor drawing IMOD at 16 V. Swept 3 / 10 mA.
* - Robot SS54 (pads -> charger IN+) reverse leakage, modelled as a resistor that passes ILEAK at 16 V:
*   10 uA (typical, 25 °C), 1 mA (max at 25 °C, 40 V), 50 mA (max at 100 °C: just after a 1.5 A charge the
*   SS54 runs ≈ 0.8 W, 60 °C/W). The module's own freewheel diode gets the same leakage.
* - Pad side: dock-sense divider R3 100 k / R4 10 k to robot GND (J18), nothing else (dock not connected).

.param ILEAK=1m IMOD=10m RFB=10k

VBUS bus 0 DC 16.8
.model DSCH D(IS=1u N=1.0 RS=0.03 CJO=300p)
.model DBODY D(IS=1e-9 N=1.3 RS=0.05)

* charger module
RLX bus sw 0.03
DFW 0 sw DSCH
RFWLK sw 0 {16/ILEAK}
DHS sw vin DBODY
RFB bus 0 {RFB}
RMOD vin 0 {16/IMOD}
CIN vin 0 220u

* robot SS54 between dock pads and the charger input
DIN pad vin DSCH
RINLK vin pad {16/ILEAK}

* dock sense divider (R3, R4, C11)
R3 pad dsense 100k
R4 dsense 0 10k
C11 dsense 0 100n

.dc VBUS 12 16.8 0.2

.control
set wr_singlescale
set wr_vecnames
run
let ibus = -i(vbus)
let dock_v = v(dsense) * 11
wrdata OUTFILE.txt ibus v(vin) v(pad) dock_v
.endc
.end
